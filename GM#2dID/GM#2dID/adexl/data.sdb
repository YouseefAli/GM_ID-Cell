ADE simulation setup
Run mode: Single Run, Sweeps and Corners
Tests:
  GM-ID:GM-ID:1: GM-ID/GM-ID/schematic, simulator spectre
    Outputs: 2_Gm_ro_Pmos; ID_W_Pmos; FT_Pmos; VGS__Pmos; Vdsat_Pmos
Global variables:
  L = 1u
  W = 10u
  VDS = 0.3
  VGS = 1
